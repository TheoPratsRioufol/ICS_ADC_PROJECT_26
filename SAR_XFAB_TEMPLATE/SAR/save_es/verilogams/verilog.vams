//Verilog-AMS HDL for "SAR", "save_es" "verilogams"

`include "constants.vams"
`include "disciplines.vams"

module save_es ( inp, s, clock );

input inp;
input [7:0] s;
input clock;
electrical inp ;
parameter print=0 ;

integer file,r ;

initial
  begin
	file = $fopen("/home/ics15/ICS_ADC_PROJECT_26/data.txt","w");
  end

always@(posedge clock)
  begin
    if ((s[0]==0) || (s[0]==1))
	  begin
		$fdisplay(file, "%f ", V(inp));
		$fdisplay(file, "%d ", s);
		$fflush(file);
		if (print!=0)
			$display("valeur numrique : %d ", s);
	  end
  end

endmodule
