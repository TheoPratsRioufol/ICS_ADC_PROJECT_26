simulator lang=spectre
include "/usr/local/XFAB/xh018/cadence/v10_1/spectre/v10_1_1/lpmos/config.scs" section=default amsd_subckt_bind=yes
include "/usr/local/XFAB/xh018/cadence/v10_1/spectre/v10_1_1/lpmos/param.scs" section=3s amsd_subckt_bind=yes
include "/usr/local/XFAB/xh018/cadence/v10_1/spectre/v10_1_1/lpmos/bip.scs" section=tm amsd_subckt_bind=yes
include "/usr/local/XFAB/xh018/cadence/v10_1/spectre/v10_1_1/lpmos/cap.scs" section=tm amsd_subckt_bind=yes
include "/usr/local/XFAB/xh018/cadence/v10_1/spectre/v10_1_1/lpmos/dio.scs" section=tm amsd_subckt_bind=yes
include "/usr/local/XFAB/xh018/cadence/v10_1/spectre/v10_1_1/lpmos/mos.scs" section=tm amsd_subckt_bind=yes
include "/usr/local/XFAB/xh018/cadence/v10_1/spectre/v10_1_1/lpmos/photo.scs" section=tm amsd_subckt_bind=yes
include "/usr/local/XFAB/xh018/cadence/v10_1/spectre/v10_1_1/lpmos/res.scs" section=tm amsd_subckt_bind=yes
