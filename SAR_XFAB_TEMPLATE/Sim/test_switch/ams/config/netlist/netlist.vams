// AMS netlist generated by the AMS Unified netlister
// IC subversion:  IC6.1.8-64b.500.36
// Xcelium version: 24.09-s011
// Copyright(C) 2005-2009, Cadence Design Systems, Inc
// User: ics15 Pid: 855613
// Design library name: SAR
// Design cell name: test_switch
// Design view name: config
// Solver: Spectre

`include "disciplines.vams"
`include "userDisciplines.vams"
// Library - SAR, Cell - test_switch, View - schematic
// LAST TIME SAVED: Jan 28 10:49:27 2026
// NETLIST TIME: Jan 28 11:18:08 2026

`worklib SAR
`view schematic

`timescale 1ns / 1ps
(* cds_ams_schematic *)

module test_switch ( );
isource #(.dc(1e-06), .type("dc")) V3 (net04, net6);
vsource #(.dc(1.65), .type("dc")) V5 (net6, cds_globals.\gnd! );
vsource #(.dc(3.3), .type("dc")) V4 (cds_globals.\vdd! , cds_globals.\gnd! );
vsource #(.dc(3.3), .type("dc")) V0 (net3, cds_globals.\gnd! );
vcvs #(.gain(1000000)) E0 (R, cds_globals.\gnd! , net6, net04);

endmodule
`noworklib
`noview
