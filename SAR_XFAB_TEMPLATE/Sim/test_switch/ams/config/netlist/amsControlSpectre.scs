// This is the Cadence AMS Designer(R) analog simulation control file.
// It specifies the options and analyses for the Spectre analog solver.

simulator lang=spectre

global 0 vdd!

simulatorOptions options psfversion="1.4.0" temp=27 tnom=27 scale=1.0 \
scalem=1.0 reltol=1e-3 vabstol=1e-6 iabstol=1e-12 gmin=1e-12 rforce=1 \
maxnotes=5 maxwarns=5 digits=5 pivrel=1e-3 checklimitdest=psf
dcOp dc write="spectre.dc" maxiters=150 maxsteps=10000 annotate=status
dcOpInfo info what=oppoint where=rawfile

modelParameter info what=models where=rawfile
element info what=inst where=rawfile
outputParameter info what=output where=rawfile
designParamVals info what=parameters where=rawfile
primitives info what=primitives where=rawfile
subckts info what=subckts where=rawfile
