// Design: SAR/test_switch
simulator lang=spectre
global 0 vdd!
parameters L=0.35u wn=9u wp=4.1*wn
include "/usr/local/XFAB/xh018/cadence/v10_1/spectre/v10_1_1/lpmos/config.scs" section=default
include "/usr/local/XFAB/xh018/cadence/v10_1/spectre/v10_1_1/lpmos/param.scs" section=3s
include "/usr/local/XFAB/xh018/cadence/v10_1/spectre/v10_1_1/lpmos/bip.scs" section=tm
include "/usr/local/XFAB/xh018/cadence/v10_1/spectre/v10_1_1/lpmos/cap.scs" section=tm
include "/usr/local/XFAB/xh018/cadence/v10_1/spectre/v10_1_1/lpmos/dio.scs" section=tm
include "/usr/local/XFAB/xh018/cadence/v10_1/spectre/v10_1_1/lpmos/mos.scs" section=tm
include "/usr/local/XFAB/xh018/cadence/v10_1/spectre/v10_1_1/lpmos/photo.scs" section=tm
include "/usr/local/XFAB/xh018/cadence/v10_1/spectre/v10_1_1/lpmos/res.scs" section=tm

// SAR/switch/schematic
subckt switch CMD\+ CMD\- S\+ S\-
    M0 (S\+ CMD\+ S\- 0) ne3 w=wn/1 l=L m=(1)*(1)
    M1 (S\- CMD\- S\+ vdd!) pe3 w=wp/1 l=L m=(1)*(1)
ends switch

// SAR/test_switch/schematic
V3 (net04 net6) isource dc=1u type=dc
V5 (net6 0) vsource dc=1.65 type=dc
V4 (vdd! 0) vsource dc=3.3 type=dc
V0 (net3 0) vsource dc=3.3 type=dc
E0 (R 0 net6 net04) vcvs gain=1000000
I2 (net3 0 net6 net04) switch
simulatorOptions options temp=27 compatible=spice2
dcOp dc
dc dc dev=V5 param=dc start=0 stop=3.3
save R 0 net6 net3
saveOptions options save=all currents=all
