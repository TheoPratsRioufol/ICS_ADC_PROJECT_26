// -----------------------------------------------------------------------------
// (c) Copyright 2010 Cadence Design Systems, Inc. All rights reserved worldwide.
// -----------------------------------------------------------------------------

// Binding AMSD Control Block for config SAR.test_sar8:config
// Created On: Feb 24 17:24:49 2026
// NOTE      : DO NOT change this system generated file.

amsd {
	config designtop="SAR.test_sar8:schematic"

	config cell="voltage_gene" lib="SAR" view="verilogams"
	config cell="vcvs" view="analogtext"
	config cell="pe3" view="analogtext"
	config cell="IN_3VX4" lib="D_CELLS_3V" view="verilogams"
	config cell="switched_comparator" lib="SAR" view="verilogams"
	config cell="digital_part" lib="SAR" view="a3"
	config cell="switch" lib="SAR" view="schematic"
	config cell="capacitor" view="analogtext"
	config cell="sar8" lib="SAR" view="schematic"
	config cell="ne3" view="analogtext"
	config cell="vsource" view="analogtext"
	config cell="save_es" lib="SAR" view="verilogams"
	config cell="NA2_3VX1" lib="D_CELLS_3V" view="verilogams"
	config cell="digital_gene" lib="SAR" view="a1"
	config cell="switch2" lib="SAR" view="schematic"

 }
