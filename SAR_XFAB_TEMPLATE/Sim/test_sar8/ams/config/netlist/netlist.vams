// AMS netlist generated by the AMS Unified netlister
// IC subversion:  IC6.1.8-64b.500.36
// Xcelium version: 24.09-s011
// Copyright(C) 2005-2009, Cadence Design Systems, Inc
// User: ics15 Pid: 114840
// Design library name: SAR
// Design cell name: test_sar8
// Design view name: config
// Solver: Spectre

`include "disciplines.vams"
`include "userDisciplines.vams"
// HDL file - SAR, voltage_gene, verilogams.
// HDL file - SAR, digital_gene, a1.
// HDL file - SAR, save_es, verilogams.
// HDL file - D_CELLS_3V, NA2_3VX1, verilogams.
// HDL file - SAR, switched_comparator, verilogams.
// HDL file - SAR, digital_part, a3.
// HDL file - D_CELLS_3V, IN_3VX4, verilogams.
// Library - SAR, Cell - switch, View - schematic
// LAST TIME SAVED: Jan 28 11:59:46 2026
// NETLIST TIME: Feb 24 17:24:44 2026

`worklib SAR
`view schematic

`timescale 1ns / 1ps
(* cds_ams_schematic *)

module switch (\S+ , \S- , \CMD+ , \CMD- );
input  \CMD+ , \CMD- ;
inout  \S+ , \S- ;
ne3 #(.w(cds_globals.wn/1), .l(cds_globals.L), .as(4.8e-07*(cds_globals.wn/1)), .ad(4.8e-07*(cds_globals.wn/1)), .ps(1*2*(4.8e-07+(cds_globals.wn/1))), .pd(2*(4.8e-07+(cds_globals.wn/1))), .nrs(2.7e-07/(cds_globals.wn/1)), .nrd(2.7e-07/(cds_globals.wn/1)), .m((1)*(1)), .par1((1)*(1)), .xf_subext(0))
(* integer passed_mfactor = "m"; *)
 M0 (\S+ , \CMD+ , \S- , cds_globals.\gnd! );
pe3 #(.w(cds_globals.wp/1), .l(cds_globals.L), .as(4.8e-07*(cds_globals.wp/1)), .ad(4.8e-07*(cds_globals.wp/1)), .ps(1*2*(4.8e-07+(cds_globals.wp/1))), .pd(2*(4.8e-07+(cds_globals.wp/1))), .nrs(2.7e-07/(cds_globals.wp/1)), .nrd(2.7e-07/(cds_globals.wp/1)), .m((1)*(1)), .par1((1)*(1)))
(* integer passed_mfactor = "m"; *)
 M1 (\S- , \CMD- , \S+ , cds_globals.\vdd! );

endmodule
// Library - SAR, Cell - switch2, View - schematic
// LAST TIME SAVED: Feb  5 15:39:33 2026
// NETLIST TIME: Feb 24 17:24:44 2026

`worklib SAR
`view schematic

`timescale 1ns / 1ps
(* cds_ams_schematic *)

module switch2 (\S- , S1, S2, \CMD+ , \CMD- );
input  \CMD+ , \CMD- ;
inout  \S- , S1, S2;
switch I1 (.\S+ ( \S-  ), .\CMD+ ( \CMD+  ), .\CMD- ( \CMD-  ), .\S- ( S2 ));
switch I0 (.\S+ ( \S-  ), .\CMD+ ( \CMD-  ), .\CMD- ( \CMD+  ), .\S- ( S1 ));

endmodule
// Library - SAR, Cell - sar8, View - schematic
// LAST TIME SAVED: Feb 24 16:52:25 2026
// NETLIST TIME: Feb 24 17:24:44 2026

`worklib SAR
`view schematic

`timescale 1ns / 1ps
(* cds_ams_schematic *)

module sar8 (result, Analog_in, clock, reset, start);
input  Analog_in, clock, reset, start;
output [7:0] result;
wire [0:3] net3;
wire [8:0] Sm;
wire [7:0] partialResultFlag;
wire [8:0] Sp;
wire clk_bar;
wire VA;
wire SAm;
wire SAp;
wire Vref2;
wire comp;
wire SBp;
wire SBm;
wire clkcomp;
wire stateSample;
wire stateHold;
wire stateCompare;
wire debugFlag;
wire net26;
wire VB;
wire Vref;
wire net19;
wire net21;
wire net20;
wire net12;
wire net13;
wire net9;
wire net6;
wire net2;
wire outn;
wire outp;
wire net1;
IN_3VX4 I77 (.A( clock ), .Q( clk_bar ));
switch SA (.\S+ ( Vref2 ), .\CMD+ ( SAp ), .\CMD- ( SAm ), .\S- ( VA ));
digital_part I9 (.contflag( net3 ), .debugflag( debugFlag ), .partialresultflag( partialResultFlag ), .statecompare( stateCompare ), .statehold( stateHold ), .statesample( stateSample ), .clkcomp( clkcomp ), .start( start ), .clock( clock ), .reset( reset ), .result( result ), .sm( Sm ), .sp( Sp ), .sam( SAm ), .sap( SAp ), .sbm( SBm ), .sbp( SBp ), .comp( comp ));
switch2 I34 (.S2( VB ), .S1(cds_globals.\gnd! ), .\CMD+ ( Sp[4] ), .\CMD- ( Sm[4] ), .\S- ( net26 ));
switch2 SB (.S2( Vref ), .S1( Analog_in ), .\CMD+ ( SBp ), .\CMD- ( SBm ), .\S- ( VB ));
switch2 I35 (.S2( VB ), .S1(cds_globals.\gnd! ), .\CMD+ ( Sp[5] ), .\CMD- ( Sm[5] ), .\S- ( net19 ));
switch2 I37 (.S2( VB ), .S1(cds_globals.\gnd! ), .\CMD+ ( Sp[6] ), .\CMD- ( Sm[6] ), .\S- ( net21 ));
switch2 I36 (.S2( VB ), .S1(cds_globals.\gnd! ), .\CMD+ ( Sp[7] ), .\CMD- ( Sm[7] ), .\S- ( net20 ));
switch2 I38 (.S2( VB ), .S1(cds_globals.\gnd! ), .\CMD+ ( Sp[2] ), .\CMD- ( Sm[2] ), .\S- ( net12 ));
switch2 I39 (.S2( VB ), .S1(cds_globals.\gnd! ), .\CMD+ ( Sp[3] ), .\CMD- ( Sm[3] ), .\S- ( net13 ));
switch2 I40 (.S2( VB ), .S1(cds_globals.\gnd! ), .\CMD+ ( Sp[1] ), .\CMD- ( Sm[1] ), .\S- ( net9 ));
switch2 S0 (.S2( VB ), .S1(cds_globals.\gnd! ), .\CMD+ ( Sp[0] ), .\CMD- ( Sm[0] ), .\S- ( net6 ));
switch2 I42 (.S2( VB ), .S1(cds_globals.\gnd! ), .\CMD+ ( Sp[8] ), .\CMD- ( Sm[8] ), .\S- ( net2 ));
switched_comparator I63 (.Outp( outp ), .vdda(cds_globals.\vdd3! ), .gnda(cds_globals.\gnd! ), .vinm( VA ), .Outn( outn ), .clock( clk_bar ), .vinp( Vref2 ));
NA2_3VX1 I79 (.B( outn ), .Q( net1 ), .A( comp ));
NA2_3VX1 I78 (.B( outp ), .Q( comp ), .A( net1 ));
vsource #(.dc(cds_globals.Vcm), .type("dc")) V5 (Vcm, cds_globals.\gnd! );
vsource #(.dc(3.3), .type("dc")) V1 (Vref, cds_globals.\gnd! );
vsource #(.dc(3.3), .type("dc")) V3 (cds_globals.\vdd3! , cds_globals.\gnd! );
capacitor #(.c(cds_globals.C/16)) C0 (net26, VA);
capacitor #(.c(cds_globals.C/4)) C3 (net21, VA);
capacitor #(.c(cds_globals.C/2)) C2 (net20, VA);
capacitor #(.c(cds_globals.C/8)) C1 (net19, VA);
capacitor #(.c(cds_globals.C/32)) C4 (net13, VA);
capacitor #(.c(cds_globals.C/64)) C5 (net12, VA);
capacitor #(.c(cds_globals.C/128)) C6 (net9, VA);
capacitor #(.c(cds_globals.C/128)) C7 (net6, VA);
capacitor #(.c(cds_globals.C)) C8 (net2, VA);
vcvs #(.gain(0.5)) E0 (Vref2, cds_globals.\gnd! , Vref, cds_globals.\gnd! );

endmodule
// Library - SAR, Cell - test_sar8, View - schematic
// LAST TIME SAVED: Feb 24 17:19:24 2026
// NETLIST TIME: Feb 24 17:24:44 2026

`worklib SAR
`view schematic

`timescale 1ns / 1ps
(* cds_ams_schematic *)

module test_sar8 ( );
wire [7:0] result;
wire start;
wire reset;
wire clock;
wire Analog_in;
sar8 I19 (.result( result[7:0] ), .Analog_in( Analog_in ), .clock( clock ), .reset( reset ), .start( start ));
save_es I18 (.s( result ), .clock( start ), .inp( Analog_in ));
digital_gene I16 (.start( start ), .clock( clock ), .reset( reset ));
voltage_gene I17 (.vout_n(cds_globals.\gnd! ), .vout_p( Analog_in ), .clock( start ));
vsource #(.dc(3.3), .type("dc")) V0 (cds_globals.\vdd! , cds_globals.\gnd! );

endmodule
`noworklib
`noview
