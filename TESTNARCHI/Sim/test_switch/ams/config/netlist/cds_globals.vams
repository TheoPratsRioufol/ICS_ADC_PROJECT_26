// Verilog-AMS cds_globals module for top-level cell:
//    SAR/test_switch.
// Generated by ADE.
// Cadence Design Systems, Inc.

// This is an autoGenerated file, any changes done to this file may get lost.

`include "disciplines.vams"
`include "userDisciplines.vams"

module cds_globals;

// Global Signals
   wire \vdd! ;
   electrical \gnd! ;
   ground \gnd! ;

// Design Variables
   dynamicparam real wp = 3.8u;
   dynamicparam real wn = 1u;

endmodule
