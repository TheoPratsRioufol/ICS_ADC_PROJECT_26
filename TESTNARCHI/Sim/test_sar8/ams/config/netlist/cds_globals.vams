// Verilog-AMS cds_globals module for top-level cell:
//    SAR/test_sar8.
// Generated by ADE.
// Cadence Design Systems, Inc.

// This is an autoGenerated file, any changes done to this file may get lost.

`include "disciplines.vams"
`include "userDisciplines.vams"

module cds_globals;

// Global Signals
   wire \vdd! ;
   electrical \gnd! ;
   ground \gnd! ;
   wire \vdd3! ;

// Design Variables
   dynamicparam real C = 25.6p;
   dynamicparam real L = 350n;
   dynamicparam real wn = 9u;
   dynamicparam real Vref = 3.3;
   dynamicparam real Vcm = Vref/2;
   dynamicparam real wp = 4.1*wn;

endmodule
